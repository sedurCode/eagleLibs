defun( AFn_OpenDesign (@key design, (mode "w"), noMru, noConfirm, forceNew)
 let((noconfirmStatus, result)
  when(noConfirm, noconfirmStatus = axlGetVariable("NOCONFIRM"), axlSetVariable("NOCONFIRM", t))
  when(forceNew && isFile(design), deleteFile(design))
  result = if(noMru && axlVersion('version) >= 16.0
   then axlOpenDesign(?design design, ?mode mode, ?noMru t)
   else axlOpenDesign(?design design, ?mode mode)
  )
  when(noConfirm, if(noconfirmStatus then axlSetVariable("NOCONFIRM", t) else axlUnsetVariable("NOCONFIRM")))
  result
))
procedure( CreatePadstacks()
    axlDBChangeDesignUnits("millimeters" 4)
    pad_list0 = cons(make_axlPadStackPad(
        ?layer "TOP", ?type 'REGULAR,
        ?figure 'RECTANGLE, ?figureSize 0.3:1.475) nil)
    ps_id = axlDBCreatePadStack("r147-5_30", nil, pad_list0 t)
    axlPadstackToDisk("r147-5_30")
)
procedure( BuildFootprint()
    AFn_OpenDesign(?design strcat("QFP50P1200X1200X160-64N", ".dra"), ?mode "wf", ?noMru t, ?noConfirm t, ?forceNew t)
    axlSetSymbolType("package")
    mytext = make_axlTextOrientation(?textBlock 6, ?rotation 0, ?mirrored nil, ?justify "center")
    mypin = make_axlPinText(?number "1", ?offset 0:0, ?text mytext)
    axlDBCreatePin("r147-5_30" 94.262:103.75 mypin 90)
    mypin = make_axlPinText(?number "2", ?offset 0:0, ?text mytext)
    axlDBCreatePin("r147-5_30" 94.262:103.25 mypin 90)
    mypin = make_axlPinText(?number "3", ?offset 0:0, ?text mytext)
    axlDBCreatePin("r147-5_30" 94.262:102.75 mypin 90)
    mypin = make_axlPinText(?number "4", ?offset 0:0, ?text mytext)
    axlDBCreatePin("r147-5_30" 94.262:102.25 mypin 90)
    mypin = make_axlPinText(?number "5", ?offset 0:0, ?text mytext)
    axlDBCreatePin("r147-5_30" 94.262:101.75 mypin 90)
    mypin = make_axlPinText(?number "6", ?offset 0:0, ?text mytext)
    axlDBCreatePin("r147-5_30" 94.262:101.25 mypin 90)
    mypin = make_axlPinText(?number "7", ?offset 0:0, ?text mytext)
    axlDBCreatePin("r147-5_30" 94.262:100.75 mypin 90)
    mypin = make_axlPinText(?number "8", ?offset 0:0, ?text mytext)
    axlDBCreatePin("r147-5_30" 94.262:100.25 mypin 90)
    mypin = make_axlPinText(?number "9", ?offset 0:0, ?text mytext)
    axlDBCreatePin("r147-5_30" 94.262:99.75 mypin 90)
    mypin = make_axlPinText(?number "10", ?offset 0:0, ?text mytext)
    axlDBCreatePin("r147-5_30" 94.262:99.25 mypin 90)
    mypin = make_axlPinText(?number "11", ?offset 0:0, ?text mytext)
    axlDBCreatePin("r147-5_30" 94.262:98.75 mypin 90)
    mypin = make_axlPinText(?number "12", ?offset 0:0, ?text mytext)
    axlDBCreatePin("r147-5_30" 94.262:98.25 mypin 90)
    mypin = make_axlPinText(?number "13", ?offset 0:0, ?text mytext)
    axlDBCreatePin("r147-5_30" 94.262:97.75 mypin 90)
    mypin = make_axlPinText(?number "14", ?offset 0:0, ?text mytext)
    axlDBCreatePin("r147-5_30" 94.262:97.25 mypin 90)
    mypin = make_axlPinText(?number "15", ?offset 0:0, ?text mytext)
    axlDBCreatePin("r147-5_30" 94.262:96.75 mypin 90)
    mypin = make_axlPinText(?number "16", ?offset 0:0, ?text mytext)
    axlDBCreatePin("r147-5_30" 94.262:96.25 mypin 90)
    mypin = make_axlPinText(?number "17", ?offset 0:0, ?text mytext)
    axlDBCreatePin("r147-5_30" 96.25:94.262 mypin 180)
    mypin = make_axlPinText(?number "18", ?offset 0:0, ?text mytext)
    axlDBCreatePin("r147-5_30" 96.75:94.262 mypin 180)
    mypin = make_axlPinText(?number "19", ?offset 0:0, ?text mytext)
    axlDBCreatePin("r147-5_30" 97.25:94.262 mypin 180)
    mypin = make_axlPinText(?number "20", ?offset 0:0, ?text mytext)
    axlDBCreatePin("r147-5_30" 97.75:94.262 mypin 180)
    mypin = make_axlPinText(?number "21", ?offset 0:0, ?text mytext)
    axlDBCreatePin("r147-5_30" 98.25:94.262 mypin 180)
    mypin = make_axlPinText(?number "22", ?offset 0:0, ?text mytext)
    axlDBCreatePin("r147-5_30" 98.75:94.262 mypin 180)
    mypin = make_axlPinText(?number "23", ?offset 0:0, ?text mytext)
    axlDBCreatePin("r147-5_30" 99.25:94.262 mypin 180)
    mypin = make_axlPinText(?number "24", ?offset 0:0, ?text mytext)
    axlDBCreatePin("r147-5_30" 99.75:94.262 mypin 180)
    mypin = make_axlPinText(?number "25", ?offset 0:0, ?text mytext)
    axlDBCreatePin("r147-5_30" 100.25:94.262 mypin 180)
    mypin = make_axlPinText(?number "26", ?offset 0:0, ?text mytext)
    axlDBCreatePin("r147-5_30" 100.75:94.262 mypin 180)
    mypin = make_axlPinText(?number "27", ?offset 0:0, ?text mytext)
    axlDBCreatePin("r147-5_30" 101.25:94.262 mypin 180)
    mypin = make_axlPinText(?number "28", ?offset 0:0, ?text mytext)
    axlDBCreatePin("r147-5_30" 101.75:94.262 mypin 180)
    mypin = make_axlPinText(?number "29", ?offset 0:0, ?text mytext)
    axlDBCreatePin("r147-5_30" 102.25:94.262 mypin 180)
    mypin = make_axlPinText(?number "30", ?offset 0:0, ?text mytext)
    axlDBCreatePin("r147-5_30" 102.75:94.262 mypin 180)
    mypin = make_axlPinText(?number "31", ?offset 0:0, ?text mytext)
    axlDBCreatePin("r147-5_30" 103.25:94.262 mypin 180)
    mypin = make_axlPinText(?number "32", ?offset 0:0, ?text mytext)
    axlDBCreatePin("r147-5_30" 103.75:94.262 mypin 180)
    mypin = make_axlPinText(?number "33", ?offset 0:0, ?text mytext)
    axlDBCreatePin("r147-5_30" 105.738:96.25 mypin 90)
    mypin = make_axlPinText(?number "34", ?offset 0:0, ?text mytext)
    axlDBCreatePin("r147-5_30" 105.738:96.75 mypin 90)
    mypin = make_axlPinText(?number "35", ?offset 0:0, ?text mytext)
    axlDBCreatePin("r147-5_30" 105.738:97.25 mypin 90)
    mypin = make_axlPinText(?number "36", ?offset 0:0, ?text mytext)
    axlDBCreatePin("r147-5_30" 105.738:97.75 mypin 90)
    mypin = make_axlPinText(?number "37", ?offset 0:0, ?text mytext)
    axlDBCreatePin("r147-5_30" 105.738:98.25 mypin 90)
    mypin = make_axlPinText(?number "38", ?offset 0:0, ?text mytext)
    axlDBCreatePin("r147-5_30" 105.738:98.75 mypin 90)
    mypin = make_axlPinText(?number "39", ?offset 0:0, ?text mytext)
    axlDBCreatePin("r147-5_30" 105.738:99.25 mypin 90)
    mypin = make_axlPinText(?number "40", ?offset 0:0, ?text mytext)
    axlDBCreatePin("r147-5_30" 105.738:99.75 mypin 90)
    mypin = make_axlPinText(?number "41", ?offset 0:0, ?text mytext)
    axlDBCreatePin("r147-5_30" 105.738:100.25 mypin 90)
    mypin = make_axlPinText(?number "42", ?offset 0:0, ?text mytext)
    axlDBCreatePin("r147-5_30" 105.738:100.75 mypin 90)
    mypin = make_axlPinText(?number "43", ?offset 0:0, ?text mytext)
    axlDBCreatePin("r147-5_30" 105.738:101.25 mypin 90)
    mypin = make_axlPinText(?number "44", ?offset 0:0, ?text mytext)
    axlDBCreatePin("r147-5_30" 105.738:101.75 mypin 90)
    mypin = make_axlPinText(?number "45", ?offset 0:0, ?text mytext)
    axlDBCreatePin("r147-5_30" 105.738:102.25 mypin 90)
    mypin = make_axlPinText(?number "46", ?offset 0:0, ?text mytext)
    axlDBCreatePin("r147-5_30" 105.738:102.75 mypin 90)
    mypin = make_axlPinText(?number "47", ?offset 0:0, ?text mytext)
    axlDBCreatePin("r147-5_30" 105.738:103.25 mypin 90)
    mypin = make_axlPinText(?number "48", ?offset 0:0, ?text mytext)
    axlDBCreatePin("r147-5_30" 105.738:103.75 mypin 90)
    mypin = make_axlPinText(?number "49", ?offset 0:0, ?text mytext)
    axlDBCreatePin("r147-5_30" 103.75:105.738 mypin 180)
    mypin = make_axlPinText(?number "50", ?offset 0:0, ?text mytext)
    axlDBCreatePin("r147-5_30" 103.25:105.738 mypin 180)
    mypin = make_axlPinText(?number "51", ?offset 0:0, ?text mytext)
    axlDBCreatePin("r147-5_30" 102.75:105.738 mypin 180)
    mypin = make_axlPinText(?number "52", ?offset 0:0, ?text mytext)
    axlDBCreatePin("r147-5_30" 102.25:105.738 mypin 180)
    mypin = make_axlPinText(?number "53", ?offset 0:0, ?text mytext)
    axlDBCreatePin("r147-5_30" 101.75:105.738 mypin 180)
    mypin = make_axlPinText(?number "54", ?offset 0:0, ?text mytext)
    axlDBCreatePin("r147-5_30" 101.25:105.738 mypin 180)
    mypin = make_axlPinText(?number "55", ?offset 0:0, ?text mytext)
    axlDBCreatePin("r147-5_30" 100.75:105.738 mypin 180)
    mypin = make_axlPinText(?number "56", ?offset 0:0, ?text mytext)
    axlDBCreatePin("r147-5_30" 100.25:105.738 mypin 180)
    mypin = make_axlPinText(?number "57", ?offset 0:0, ?text mytext)
    axlDBCreatePin("r147-5_30" 99.75:105.738 mypin 180)
    mypin = make_axlPinText(?number "58", ?offset 0:0, ?text mytext)
    axlDBCreatePin("r147-5_30" 99.25:105.738 mypin 180)
    mypin = make_axlPinText(?number "59", ?offset 0:0, ?text mytext)
    axlDBCreatePin("r147-5_30" 98.75:105.738 mypin 180)
    mypin = make_axlPinText(?number "60", ?offset 0:0, ?text mytext)
    axlDBCreatePin("r147-5_30" 98.25:105.738 mypin 180)
    mypin = make_axlPinText(?number "61", ?offset 0:0, ?text mytext)
    axlDBCreatePin("r147-5_30" 97.75:105.738 mypin 180)
    mypin = make_axlPinText(?number "62", ?offset 0:0, ?text mytext)
    axlDBCreatePin("r147-5_30" 97.25:105.738 mypin 180)
    mypin = make_axlPinText(?number "63", ?offset 0:0, ?text mytext)
    axlDBCreatePin("r147-5_30" 96.75:105.738 mypin 180)
    mypin = make_axlPinText(?number "64", ?offset 0:0, ?text mytext)
    axlDBCreatePin("r147-5_30" 96.25:105.738 mypin 180)
    axlDBCreateText("IC*" 100:100 "2" "REF DES/SILKSCREEN_TOP")
    axlDBCreateLine((list 93.275:106.725 106.725:106.725), 0.05, "PACKAGE GEOMETRY/PLACE_BOUND_TOP")
    axlDBCreateLine((list 106.725:106.725 106.725:93.275), 0.05, "PACKAGE GEOMETRY/PLACE_BOUND_TOP")
    axlDBCreateLine((list 106.725:93.275 93.275:93.275), 0.05, "PACKAGE GEOMETRY/PLACE_BOUND_TOP")
    axlDBCreateLine((list 93.275:93.275 93.275:106.725), 0.05, "PACKAGE GEOMETRY/PLACE_BOUND_TOP")
    axlDBCreateLine((list 95:105 105:105), 0.1, "PACKAGE GEOMETRY/ASSEMBLY_TOP")
    axlDBCreateLine((list 105:105 105:95), 0.1, "PACKAGE GEOMETRY/ASSEMBLY_TOP")
    axlDBCreateLine((list 105:95 95:95), 0.1, "PACKAGE GEOMETRY/ASSEMBLY_TOP")
    axlDBCreateLine((list 95:95 95:105), 0.1, "PACKAGE GEOMETRY/ASSEMBLY_TOP")
    axlDBCreateLine((list 95:104.5 95.5:105), 0.1, "PACKAGE GEOMETRY/ASSEMBLY_TOP")
    axlDBCreateLine((list 95.35:104.65 104.65:104.65), 0.2, "PACKAGE GEOMETRY/SILKSCREEN_TOP")
    axlDBCreateLine((list 104.65:104.65 104.65:95.35), 0.2, "PACKAGE GEOMETRY/SILKSCREEN_TOP")
    axlDBCreateLine((list 104.65:95.35 95.35:95.35), 0.2, "PACKAGE GEOMETRY/SILKSCREEN_TOP")
    axlDBCreateLine((list 95.35:95.35 95.35:104.65), 0.2, "PACKAGE GEOMETRY/SILKSCREEN_TOP")
    axlDBCreateCircle((list 93.775:104.5 0.125), 0.25, "PACKAGE GEOMETRY/SILKSCREEN_TOP")
    ;axlCompileSymbol(?symbol "QFP50P1200X1200X160-64N", ?type "package")
    axlSaveDesign(?noMru t)
)
